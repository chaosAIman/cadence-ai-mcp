* RC Low-Pass Filter
V1  in  0  SIN(0 5 1k 0 0 0)
R1  in  out  1k
C1  out 0   100n
.TRAN 1us 3ms
.PROBE
.END
